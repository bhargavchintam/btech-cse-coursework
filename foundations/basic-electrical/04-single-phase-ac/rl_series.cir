RL series ac response
* R = 100 ohm, L = 100 mH, driven by a 1 V ac source
* R is put at the ground end so v(2) sits straight across it (= I*R)
* checked at f = 50 Hz : XL = 31.42, |Z| = 104.82, I = 9.54 mA, current lags by 17.44 deg
V1 1 0 AC 1
L1 1 2 100m
R1 2 0 100
.ac dec 20 10 1k
.control
set units = degrees
run
meas ac vR_50  FIND vm(2) AT=50
meas ac iphase FIND vp(2) AT=50
.endc
* expected: vm(2) = 0.954 V across R  ->  I = vR/R = 9.54 mA, vp(2) = -17.44 deg (I lags)
.end

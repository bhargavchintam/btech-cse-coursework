RC series ac response
* R = 1k, C = 1u, driven by a 1 V ac source
* R is put at the ground end so v(2) sits straight across it (= I*R)
* checked at f = 50 Hz : XC = 3183, |Z| = 3336, I = 0.300 mA, current leads by 72.56 deg
V1 1 0 AC 1
C1 1 2 1u
R1 2 0 1k
.ac dec 20 10 1k
.control
set units = degrees
run
meas ac vR_50  FIND vm(2) AT=50
meas ac iphase FIND vp(2) AT=50
.endc
* expected: vm(2) = 0.2997 V across R  ->  I = vR/R = 0.300 mA, vp(2) = +72.56 deg (I leads)
.end

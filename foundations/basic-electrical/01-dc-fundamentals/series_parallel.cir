Mixed series-parallel network
* R1 in series feeding node 2; at node 2, R2 is in parallel with (R3+R4)
V1 1 0 DC 9
R1 1 2 1k
R2 2 0 3k
R3 2 3 2k
R4 3 0 4k
* R2 || (R3+R4) = 3k || 6k = 2k, total = 3k, I = 3mA
* expected: V(1)=9V, V(2)=6V, V(3)=4V
.control
op
print v(1) v(2) v(3)
.endc
.end
